* The early-70s British "graphic-panel" 120 W head (Mk II circuit), the preamp solved as a
* circuit from the 1972 schematics as redrawn by B. Hickmott (el34world).
* V1A (220k / 2.2k / 50u) into its own tone stack: a Baxandall-like
* sum of a Bass network (100k into a 1M pot with 2.2n top-to-wiper, 22n
* wiper-to-bottom, 22k to ground; wiper through 100k) and a Treble network
* (1.5n into a 1M pot over 10n). The 1M Gain pot (330p bright cap) feeds
* V1B (220k / 2.2k / 50u), then the six-way voicing switch: a chain of 4.7n, 4.7n, 2.2n,
* 1n and 330p that a six-way switch taps - each click adds a cap in
* series and takes more low end away. Then V2A (100k, 1n across the plate
* load) whose 1.5k cathode carries the HF "Boost": a 1k pot feeding a 2 mH
* choke and 0.47u to ground, a series resonance near 5 kHz that bypasses
* the cathode there. Into the cathodyne; four EL34s on a silicon bridge.
*
*@amp name="Orange OR120" based="Orange Graphic 120 Mk II" face=graphic oversample=4
*@control gain label="Gain" taper=audio default=0.5
*@control bass label="Bass" taper=audio default=0.5
*@control treble label="Treble" taper=audio default=0.5
*@control fac label="Voicing" taper=lin default=0 positions="1,2,3,4,5,6"
*@control boost label="HF Drive" taper=lin default=0.3
*@control response label="Response" taper=lin default=0.5
*@power tubes=EL34 nfb=0.25 headroom=36 count=4 pi=12AX7 rectifier=silicon bplus=480 cap=50 idle=150 full=460 rsource=25 response=response
*@input Vin
*@output out

* The guitar.
Vin src 0 0
Rpickup src in 6k

* Preamp supplies (C+ and D+, after the 33k droppers).
Vc vc 0 DC 330
Vd vd 0 DC 300

* V1A.
R68 in g1 68k
Rg1 g1 0 1meg
XV1A p1 g1 k1 TRIODE MU=100 EX=1.4 KG1=1060 KP=600 KVB=300
DG1 g1 k1 DGRID
Rk1 k1 0 2.2k
Ck1 k1 0 50u
Rp1 vd p1 220k
C1 p1 t 68n

* The tone stack: Bass network ...
Rb1 t bt 100k
XBASS bt bw bb POT R=1meg pos={bass}
Cb1 bt bw 2.2n
Cb2 bw bb 22n
Rb2 bb 0 22k
Rb3 bw o 100k
* ... and Treble network, summed at the Treble wiper.
Ct1 t tt 1.5n
XTREBLE tt o tb POT R=1meg pos={treble}
Ct2 tb 0 10n

* Gain, with its bright cap, into V1B.
XGAIN o gw 0 POT R=1meg pos={gain}
Cg o gw 330p
XV1B p2 gw k2 TRIODE MU=100 EX=1.4 KG1=1060 KP=600 KVB=300
DG2 gw k2 DGRID
Rk2 k2 0 2.2k
Ck2 k2 0 50u
Rp2 vd p2 220k
C2 p2 f0 68n

* Voicing: the switch taps a chain of series caps.
Cf1 f0 f1 4.7n
Cf2 f1 f2 4.7n
Cf3 f2 f3 2.2n
Cf4 f3 f4 1n
Cf5 f4 f5 330p
XFAC1 f0 fo SW pos={fac} k=0 n=6
XFAC2 f1 fo SW pos={fac} k=1 n=6
XFAC3 f2 fo SW pos={fac} k=2 n=6
XFAC4 f3 fo SW pos={fac} k=3 n=6
XFAC5 f4 fo SW pos={fac} k=4 n=6
XFAC6 f5 fo SW pos={fac} k=5 n=6

* V2A (through the 100k of the reverb loop), 1n across its plate load,
* the HF Drive network on its cathode.
Rin2 fo g3 100k
Rg3 g3 0 200k
XV2A p3 g3 k3 TRIODE MU=100 EX=1.4 KG1=1060 KP=600 KVB=300
DG3 g3 k3 DGRID
Rp3 vc p3 100k
Cp3 vc p3 1n
Rk3 k3 0 1.5k
XBOOST k3 bw2 0 POT R=1k pos={boost}
Lb bw2 bl 2m
Cbst bl 0 0.47u

* Into the cathodyne phase inverter's grid.
C3 p3 out 68n
Rpi out 0 1meg

.model DGRID D(IS=1n N=1.5 RS=1k)

.subckt TRIODE p g k MU=100 EX=1.4 KG1=1060 KP=600 KVB=300
B1 p k I = { pwr(max(V(p,k)/KP*ln(1+exp(KP*(1/MU+V(g,k)/sqrt(KVB+V(p,k)*V(p,k))))), 0), EX) / KG1 }
.ends

.subckt POT a w b R=10k pos=0.5
Ra a w {R*(1-pos)+1}
Rb w b {R*pos+1}
.ends

* A switch throw: closed (1 ohm) at position k of n, open (1 Gohm) otherwise.
.subckt SW a b pos=0 k=0 n=2
R1 a b {abs(pos*(n-1)-k) < 0.5 ? 1 : 1e9}
.ends

.param gain=0.1545
.param bass=0.1545
.param treble=0.1545
.param fac=0
.param boost=0.3
.param response=0.5
.end
